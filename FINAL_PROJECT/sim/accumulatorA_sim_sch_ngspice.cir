* ngspice copy of accumulatorA_sim_sch.spi. Only change: .tran 10p 240n (ngspice needs a step above 0).
*** Created on Sat Nov 07, 2026 23:56:38
*** Last revised on Sat Nov 07, 2026 23:56:38
*** Written on Sun Nov 08, 2026 19:35:18 by Electric VLSI Design System, version 9.07
*** Layout tech: mocmos, foundry MOSIS

*** SUBCIRCUIT muddLib07__inv_1x FROM CELL muddLib07:inv_1x{sch}
.SUBCKT muddLib07__inv_1x a y
** GLOBAL gnd
** GLOBAL vdd
Mnmos@0 y a gnd gnd N_1u L=0.6U W=2.1U
Mpmos@0 vdd a y vdd P_1u L=0.6U W=3U
.ENDS muddLib07__inv_1x

*** SUBCIRCUIT muddLib07__nand2_1x FROM CELL muddLib07:nand2_1x{sch}
.SUBCKT muddLib07__nand2_1x a b y
** GLOBAL gnd
** GLOBAL vdd
Mnmos@0 y b net@5 gnd N_1u L=0.6U W=3.6U
Mnmos@1 net@5 a gnd gnd N_1u L=0.6U W=3.6U
Mpmos@0 vdd b y vdd P_1u L=0.6U W=3.6U
Mpmos@1 vdd a y vdd P_1u L=0.6U W=3.6U
.ENDS muddLib07__nand2_1x

*** SUBCIRCUIT muddLib07__nand3_1x FROM CELL muddLib07:nand3_1x{sch}
.SUBCKT muddLib07__nand3_1x a b c y
** GLOBAL gnd
** GLOBAL vdd
Mnmos@0 net@4 b net@15 gnd N_1u L=0.6U W=4.8U
Mnmos@1 y c net@4 gnd N_1u L=0.6U W=4.8U
Mnmos@2 net@15 a gnd gnd N_1u L=0.6U W=4.8U
Mpmos@0 vdd c y vdd P_1u L=0.6U W=3.9U
Mpmos@1 vdd b y vdd P_1u L=0.6U W=3.9U
Mpmos@2 vdd a y vdd P_1u L=0.6U W=3.9U
.ENDS muddLib07__nand3_1x

*** SUBCIRCUIT accumulatorA__dff FROM CELL accumulatorA:dff{sch}
.SUBCKT accumulatorA__dff clk D Q Qb R
** GLOBAL gnd
** GLOBAL vdd
Xinv_1x@0 R clrb muddLib07__inv_1x
Xnand2_1x@0 n4 n2 n1 muddLib07__nand2_1x
Xnand2_1x@1 n2 Qb Q muddLib07__nand2_1x
Xnand3_1x@0 n1 clrb clk n2 muddLib07__nand3_1x
Xnand3_1x@1 n2 clk n4 n3 muddLib07__nand3_1x
Xnand3_1x@2 n3 clrb D n4 muddLib07__nand3_1x
Xnand3_1x@3 Q n3 clrb Qb muddLib07__nand3_1x
.ENDS accumulatorA__dff

*** SUBCIRCUIT muddLib07__invtri_c_1x FROM CELL muddLib07:invtri_c_1x{sch}
.SUBCKT muddLib07__invtri_c_1x d en y
** GLOBAL gnd
** GLOBAL vdd
Mnmos@0 net@3 en gnd gnd N_1u L=0.6U W=4.2U
Mnmos@1 y d net@3 gnd N_1u L=0.6U W=4.2U
Mnmos@2 net@6 en gnd gnd N_1u L=0.6U W=1.8U
Mpmos@0 net@1 d y vdd P_1u L=0.6U W=6U
Mpmos@1 vdd net@6 net@1 vdd P_1u L=0.6U W=6U
Mpmos@2 vdd en net@6 vdd P_1u L=0.6U W=2.7U
.ENDS muddLib07__invtri_c_1x

*** SUBCIRCUIT accumulatorA__accumulatorA FROM CELL accumulatorA:accumulatorA{sch}
.SUBCKT accumulatorA__accumulatorA A[3] A[2] A[1] A[0] AluA[3] AluA[2] AluA[1] AluA[0] ClearA EnableA IB[3] IB[2] IB[1] IB[0] LatchA MainClock
** GLOBAL gnd
** GLOBAL vdd
Xdff@0 net@12 A[0] AluA[0] net@6 net@11 accumulatorA__dff
Xdff@1 net@12 A[1] AluA[1] net@20 net@11 accumulatorA__dff
Xdff@2 net@12 A[2] AluA[2] net@34 net@11 accumulatorA__dff
Xdff@3 net@12 A[3] AluA[3] net@48 net@11 accumulatorA__dff
Xinv_1x@0 ClearA net@11 muddLib07__inv_1x
Xinvtri_c@0 net@6 EnableA IB[0] muddLib07__invtri_c_1x
Xinvtri_c@1 net@20 EnableA IB[1] muddLib07__invtri_c_1x
Xinvtri_c@2 net@34 EnableA IB[2] muddLib07__invtri_c_1x
Xinvtri_c@3 net@48 EnableA IB[3] muddLib07__invtri_c_1x
Xnand2_1x@0 LatchA MainClock net@12 muddLib07__nand2_1x
.ENDS accumulatorA__accumulatorA

.global gnd vdd

*** TOP LEVEL CELL: accumulatorA:accumulatorA_sim{sch}
Xaccumula@0 a[3] a[2] a[1] a[0] alua[3] alua[2] alua[1] alua[0] cleara enablea ib[3] ib[2] ib[1] ib[0] latcha mainclock accumulatorA__accumulatorA

* Spice Code nodes in cell cell 'accumulatorA:accumulatorA_sim{sch}'
vdd vdd 0 DC 5
vclk mainclock 0 pulse(0 5 5n 0.1n 0.1n 10n 20n)
va3 a[3] 0 pwl(0 5 70n 5 70.1n 0)
va2 a[2] 0 pwl(0 0 70n 0 70.1n 5)
va1 a[1] 0 pwl(0 5 70n 5 70.1n 0)
va0 a[0] 0 pwl(0 0 70n 0 70.1n 5)
vlatch latcha 0 pwl(0 5 60n 5 60.1n 0 100n 0 100.1n 5)
vclear cleara 0 pwl(0 5 140n 5 140.1n 0 160n 0 160.1n 5)
venable enablea 0 pwl(0 5 200n 5 200.1n 0)
vhalf half 0 DC 2.5
rib3 ib[3] half 100k
rib2 ib[2] half 100k
rib1 ib[1] half 100k
rib0 ib[0] half 100k
.include cmosedu_models.txt
.tran 10p 240n
.control
run
plot v(mainclock) v(latcha)
plot v(cleara) v(enablea)
plot v(alua[3]) v(alua[2]) v(alua[1]) v(alua[0])
plot v(ib[3]) v(ib[2]) v(ib[1]) v(ib[0])
.endc
.end
