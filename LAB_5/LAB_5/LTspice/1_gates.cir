*** SPICE deck for cell simulations{sch} from library lab_5_full_adder
*** Created on Mon Nov 02, 2026 22:18:01
*** Last revised on Mon Nov 02, 2026 22:18:01
*** Written on Mon Nov 02, 2026 22:18:02 by Electric VLSI Design System, version 9.07
*** Layout tech: mocmos, foundry MOSIS
*** UC SPICE *** , MIN_RESIST 4.0, MIN_CAPAC 0.1FF

*** SUBCIRCUIT lab_5_full_adder__NAND_2 FROM CELL lab_5_full_adder:NAND_2{sch}
.SUBCKT lab_5_full_adder__NAND_2 A B Y
** GLOBAL vdd
Mnmos@0 Y A vdd vdd PMOS L=0.6U W=1.8U
Mnmos@1 Y B vdd vdd PMOS L=0.6U W=1.8U
Mnmos@2 Y A net@8 0 NMOS L=0.6U W=1.8U
Mnmos@3 net@8 B 0 0 NMOS L=0.6U W=1.8U
.ENDS lab_5_full_adder__NAND_2

*** SUBCIRCUIT lab_5_full_adder__NOT FROM CELL lab_5_full_adder:NOT{sch}
.SUBCKT lab_5_full_adder__NOT A Y
** GLOBAL vdd
Mnmos@0 Y A vdd vdd PMOS L=0.6U W=1.8U
Mnmos@1 Y A 0 0 NMOS L=0.6U W=1.8U
.ENDS lab_5_full_adder__NOT

*** SUBCIRCUIT lab_5_full_adder__XOR_2 FROM CELL lab_5_full_adder:XOR_2{sch}
.SUBCKT lab_5_full_adder__XOR_2 A B Y
** GLOBAL vdd
Mnmos@0 notA_out A vdd vdd PMOS L=0.6U W=1.8U
Mnmos@1 notA_out A 0 0 NMOS L=0.6U W=1.8U
Mnmos@2 notB_out B vdd vdd PMOS L=0.6U W=1.8U
Mnmos@3 notB_out B 0 0 NMOS L=0.6U W=1.8U
Mnmos@4 net@25 A vdd vdd PMOS L=0.6U W=1.8U
Mnmos@5 Y notB_out net@25 vdd PMOS L=0.6U W=1.8U
Mnmos@6 net@26 B vdd vdd PMOS L=0.6U W=1.8U
Mnmos@7 Y notA_out net@26 vdd PMOS L=0.6U W=1.8U
Mnmos@8 Y A net@27 0 NMOS L=0.6U W=1.8U
Mnmos@9 net@27 B 0 0 NMOS L=0.6U W=1.8U
Mnmos@10 Y notB_out net@28 0 NMOS L=0.6U W=1.8U
Mnmos@11 net@28 notA_out 0 0 NMOS L=0.6U W=1.8U
.ENDS lab_5_full_adder__XOR_2

.global vdd

*** TOP LEVEL CELL: lab_5_full_adder:simulations{sch}
XNAND_2@0 va vb vout_nand lab_5_full_adder__NAND_2
XNOT@0 va vout_not lab_5_full_adder__NOT
XXOR_2@0 va vb vout_xor lab_5_full_adder__XOR_2

* Spice Code nodes in cell cell 'lab_5_full_adder:simulations{sch}'
vdd vdd 0 dc 5
va va 0 pulse(0v 5v 0n 1n 1n 10n 20n)
vb vb 0 pulse(0v 5v 5n 1n 1n 10n 20n)
.tran 0 40n
.include C5_models.txt
.END
